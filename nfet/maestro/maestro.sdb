ADE simulation setup
Run mode: Single Run, Sweeps and Corners
Tests:
  labs_nfet_1: labs/nfet/schematic, simulator spectre
    Variables: vgs = 570m; vds = 570m
