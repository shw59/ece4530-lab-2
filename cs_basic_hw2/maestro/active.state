ADE simulation setup
Test labs_cs_basic_hw2_1: labs/cs_basic_hw2/schematic, simulator spectre
  Models: /opt/cadence-designkits/gpdk045_v_6_0/gpdk045/../models/spectre/gpdk045.scs[mc]
  Temperature: 27.0
  Analysis dc: (saves the operating point)
  Analysis tran: stop=100n errpreset=conservative
  Analysis ac: start=100k stop=1T dec=100
Run mode: Single Run, Sweeps and Corners
