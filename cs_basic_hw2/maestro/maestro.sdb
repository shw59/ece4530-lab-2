ADE simulation setup
Run mode: Single Run, Sweeps and Corners
Tests:
  labs_cs_basic_hw2_1: labs/cs_basic_hw2/schematic, simulator spectre
